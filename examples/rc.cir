RC low-pass
V1 in 0 DC 0 AC 1 PULSE(0 1 0 1n 1n 1 2)
R1 in out 1k
C1 out 0 1u
.ac dec 2 10 100k
.tran 100u 3m
.print ac vdb(out) vp(out)
.print tran v(in) v(out)
.end
