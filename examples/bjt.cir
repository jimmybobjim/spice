NPN common-emitter, DC sweep of base supply
VCC vcc 0 12
VB  vb 0 0
RB  vb b 100k
RC  vcc c 4.7k
Q1  c b 0 npn1
.model npn1 NPN(is=1e-14 bf=100 vaf=100)
.dc VB 0 5 0.5
.print dc v(c) ic(q1) ib(q1)
